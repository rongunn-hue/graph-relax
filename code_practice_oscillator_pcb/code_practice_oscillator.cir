* Code Practice Oscillator — Continuous 670 Hz Oscillator with Keyed Output
* Auto-generated by xlate_circuit_to_spice.py from a .circuit file - see that
* script's docstring for what is and is not a verified model.

* --- connectors: these nets have no driving source in this translation, add one for whatever you're
* --- actually testing (e.g. "V1 P9V 0 DC 9" for a +9V rail feeding a connector like this) ---
* J1 (9V POWER): pin1->+9V, pin2->GND
* J2 (MORSE KEY): pin1->KEY_CTRL, pin2->GND
* J3 (PASSIVE PIEZO): pin1->AUDIO_OUT, pin2->GND

.model QN_GENERIC_NPN NPN

.subckt IDEAL_OPAMP INP INM OUT
* Generic ideal single-pole op-amp macro (VCVS, gain 100k) - NOT the real chip's vendor model.
* No supply pins, no saturation/slew/offset modeled. Replace before trusting quantitative results.
EOUT OUT 0 INP INM 100K
.ends IDEAL_OPAMP

C1 OSC_MINUS VREF 10nF
C2 OSC_OUT AUDIO_FEED 1uF
C3 P9V 0 100nF
C4 P9V 0 10uF
C5 VREF_DIV 0 10uF
Q1 AUDIO_OUT KEY_CTRL 0 QN_GENERIC_NPN  ; P2N2222A
R1 P9V VREF_DIV 10k
R2 VREF_DIV 0 10k
R3 OSC_OUT OSC_PLUS 100k
R4 OSC_PLUS VREF 100k
R5 OSC_OUT OSC_MINUS 68k
R6 AUDIO_FEED AUDIO_OUT 1k
R7 P9V KEY_CTRL 10k
XU1A OSC_PLUS OSC_MINUS OSC_OUT IDEAL_OPAMP  ; LM1458 section A
XU1B VREF_DIV VREF VREF IDEAL_OPAMP  ; LM1458 section B
* U1 V- (pin 4) -> GND, V+ (pin 8) -> +9V: real supply pins, not used by the ideal macro above

.end
