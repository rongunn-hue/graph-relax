* Code Practice Oscillator — Continuous 670 Hz Oscillator with Keyed Output
* Auto-generated by xlate_circuit_to_spice.py from a .circuit file - see that
* script's docstring for what is and is not a verified model.

* --- connectors: these nets have no driving source in this translation, add one for whatever you're
* --- actually testing (e.g. "V1 P9V 0 DC 9" for a +9V rail feeding a connector like this) ---
* J1 (9V POWER): pin1->+9V, pin2->GND
* J2 (MORSE KEY): pin1->KEY_CTRL, pin2->GND
* J3 (PASSIVE PIEZO): pin1->AUDIO_OUT, pin2->GND

.MODEL Q2N2222A_ONSEMI npn
+IS=3.88184e-14 BF=929.846 NF=1.10496 VAF=16.5003
+IKF=0.019539 ISE=1.0168e-11 NE=1.94752 BR=48.4545
+NR=1.07004 VAR=40.538 IKR=0.19539 ISC=1.0168e-11
+NC=4 RB=0.1 IRB=0.1 RBM=0.1
+RE=0.0001 RC=0.426673 XTB=0.1 XTI=1
+EG=1.05 CJE=2.23677e-11 VJE=0.582701 MJE=0.63466
+TF=4.06711e-10 XTF=3.92912 VTF=17712.6 ITF=0.4334
+CJC=2.23943e-11 VJC=0.576146 MJC=0.632796 XCJC=1
+FC=0.170253 CJS=0 VJS=0.75 MJS=0.5
+TR=1e-07 PTF=0 KF=0 AF=1

.subckt IDEAL_OPAMP INP INM VCC VEE OUT
* Generic ideal op-amp macro: a behavioral sigmoid (tanh) between VEE and VCC, steep enough to act
* like a saturating high-gain comparator - NOT the real chip's vendor model (no real slew rate,
* bandwidth, or offset modeled). Bounded by construction (no huge intermediate node voltages, unlike a
* linear-gain-then-diode-clamp approach, which is numerically fragile for a transient oscillator sim).
* Good enough for approximate comparator/relaxation-oscillator behavior; replace before trusting
* quantitative results.
BOUT OUT 0 V = (V(VCC)+V(VEE))/2 + (V(VCC)-V(VEE))/2*TANH(2E5*(V(INP)-V(INM))/(V(VCC)-V(VEE)+1E-9))
.ends IDEAL_OPAMP

C1 OSC_MINUS VREF 10nF
C2 OSC_OUT AUDIO_FEED 1uF
C3 P9V 0 100nF
C4 P9V 0 10uF
C5 VREF_DIV 0 10uF
Q1 AUDIO_OUT KEY_CTRL 0 Q2N2222A_ONSEMI  ; P2N2222A
R1 P9V VREF_DIV 10k
R2 VREF_DIV 0 10k
R3 OSC_OUT OSC_PLUS 100k
R4 OSC_PLUS VREF 100k
R5 OSC_OUT OSC_MINUS 68k
R6 AUDIO_FEED AUDIO_OUT 1k
R7 P9V KEY_CTRL 10k
XU1A OSC_PLUS OSC_MINUS P9V 0 OSC_OUT IDEAL_OPAMP  ; LM1458 section A
XU1B VREF_DIV VREF P9V 0 VREF IDEAL_OPAMP  ; LM1458 section B

.end
